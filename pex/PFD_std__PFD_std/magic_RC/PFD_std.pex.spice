* NGSPICE file created from PFD_std.ext - technology: ihp-sg13g2

.subckt PFD_std Y VDD A VSS B CLK GND D Q_N Q RESET_B F_REF UP F_VCO DN RST_N
X0 a_398_143# RST_N GND GND sg13_lv_nmos ad=38.85f pd=0.605u as=0.1701p ps=1.65u w=0.42u l=0.13u
X1 UP Q GND GND sg13_lv_nmos ad=0.1406p pd=1.12u as=0.2516p ps=2.16u w=0.74u l=0.13u
X2 a_172_448# a_683_474# a_1431_207# GND sg13_lv_nmos ad=0.3473p pd=2.71u as=0.12665p ps=1.145u w=0.74u l=0.13u
X3 a_460_n907# a_171_n602# a_397_n907# GND sg13_lv_nmos ad=0.1596p pd=1.6u as=38.85f ps=0.605u w=0.42u l=0.13u
X4 RST_N DN VDD VDD sg13_lv_pmos ad=0.2128p pd=1.5u as=0.4032p ps=2.96u w=1.12u l=0.13u
X5 a_529_521# a_172_448# VDD VDD sg13_lv_pmos ad=54.6f pd=0.68u as=0.1563p ps=1.22u w=0.42u l=0.13u
X6 a_1620_445# a_683_474# a_1431_207# VDD sg13_lv_pmos ad=52.5f pd=0.67u as=0.19115p ps=1.565u w=0.42u l=0.13u
X7 VDD RST_N a_n115_n920# VDD sg13_lv_pmos ad=0.36237p pd=2.605u as=79.8f ps=0.8u w=0.42u l=0.13u
X8 a_1619_n605# a_682_n576# a_1430_n843# VDD sg13_lv_pmos ad=52.5f pd=0.67u as=0.19115p ps=1.565u w=0.42u l=0.13u
X9 a_581_387# F_REF a_969_151# GND sg13_lv_nmos ad=0.2516p pd=2.16u as=0.43315p ps=2.205u w=0.74u l=0.13u
X10 a_1658_n703# RST_N a_1695_n605# VDD sg13_lv_pmos ad=79.8f pd=0.8u as=0.25605p ps=1.935u w=0.42u l=0.13u
X11 a_1049_426# a_581_387# a_683_474# VDD sg13_lv_pmos ad=0.43102p pd=2.145u as=0.3864p ps=2.93u w=1.12u l=0.13u
X12 a_1659_347# RST_N a_1696_445# VDD sg13_lv_pmos ad=79.8f pd=0.8u as=0.25605p ps=1.935u w=0.42u l=0.13u
X13 a_969_151# a_581_387# a_683_474# GND sg13_lv_nmos ad=0.43315p pd=2.205u as=0.2516p ps=2.16u w=0.74u l=0.13u
X14 Q_N a_1431_207# GND GND sg13_lv_nmos ad=0.1406p pd=1.12u as=0.2516p ps=2.16u w=0.74u l=0.13u
X15 a_580_n663# F_VCO a_968_n899# GND sg13_lv_nmos ad=0.2516p pd=2.16u as=0.43315p ps=2.205u w=0.74u l=0.13u
X16 Q_N a_1430_n843# VDD VDD sg13_lv_pmos ad=0.2128p pd=1.5u as=0.2014p ps=1.53u w=1.12u l=0.13u
X17 a_2231_n642# a_1430_n843# GND GND sg13_lv_nmos ad=0.2176p pd=1.96u as=0.1331p ps=1.12u w=0.64u l=0.13u
X18 a_n115_n920# VDD VDD VDD sg13_lv_pmos ad=79.8f pd=0.8u as=0.1428p ps=1.52u w=0.42u l=0.13u
X19 a_172_448# a_146_353# GND GND sg13_lv_nmos ad=0.2516p pd=2.16u as=0.1626p ps=1.415u w=0.74u l=0.13u
X20 VDD a_1431_207# a_1659_347# VDD sg13_lv_pmos ad=0.2014p pd=1.53u as=79.8f ps=0.8u w=0.42u l=0.13u
X21 GND a_1431_207# Q_N GND sg13_lv_nmos ad=0.1331p pd=1.12u as=0.1406p ps=1.12u w=0.74u l=0.13u
X22 a_1695_n605# a_1658_n703# a_1619_n605# VDD sg13_lv_pmos ad=0.25605p pd=1.935u as=52.5f ps=0.67u w=0.42u l=0.13u
X23 a_1430_n843# a_580_n663# a_1336_n843# GND sg13_lv_nmos ad=0.12665p pd=1.145u as=0.1428p ps=1.52u w=0.42u l=0.13u
X24 a_461_143# a_172_448# a_398_143# GND sg13_lv_nmos ad=0.1596p pd=1.6u as=38.85f ps=0.605u w=0.42u l=0.13u
X25 VDD RST_N a_n114_130# VDD sg13_lv_pmos ad=0.36237p pd=2.605u as=79.8f ps=0.8u w=0.42u l=0.13u
X26 a_2232_408# a_1431_207# GND GND sg13_lv_nmos ad=0.2176p pd=1.96u as=0.1331p ps=1.12u w=0.64u l=0.13u
X27 a_1430_n843# a_580_n663# a_171_n602# VDD sg13_lv_pmos ad=0.19115p pd=1.565u as=0.34p ps=2.68u w=1u l=0.13u
X28 a_968_n899# a_580_n663# a_682_n576# GND sg13_lv_nmos ad=0.43315p pd=2.205u as=0.2516p ps=2.16u w=0.74u l=0.13u
X29 a_1659_347# a_1431_207# a_1850_130# GND sg13_lv_nmos ad=0.1428p pd=1.52u as=37.8f ps=0.6u w=0.42u l=0.13u
X30 VDD a_1430_n843# a_1658_n703# VDD sg13_lv_pmos ad=0.2014p pd=1.53u as=79.8f ps=0.8u w=0.42u l=0.13u
X31 a_n20_130# VDD a_n114_130# GND sg13_lv_nmos ad=60.89999f pd=0.71u as=0.1428p ps=1.52u w=0.42u l=0.13u
X32 a_1431_207# a_581_387# a_1337_207# GND sg13_lv_nmos ad=0.12665p pd=1.145u as=0.1428p ps=1.52u w=0.42u l=0.13u
X33 Q a_2232_408# GND GND sg13_lv_nmos ad=0.1406p pd=1.12u as=0.2516p ps=2.16u w=0.74u l=0.13u
X34 a_145_n697# a_580_n663# a_n115_n920# GND sg13_lv_nmos ad=81f pd=0.81u as=0.1296p ps=1.52u w=0.42u l=0.13u
X35 RST_N Q a_2880_n919# GND sg13_lv_nmos ad=0.1368p pd=1.1u as=0.1404p ps=1.11u w=0.72u l=0.13u
X36 Q a_2232_408# VDD VDD sg13_lv_pmos ad=0.2156p pd=1.505u as=0.3808p ps=2.92u w=1.12u l=0.13u
X37 VDD a_1430_n843# Q_N VDD sg13_lv_pmos ad=0.2083p pd=1.5u as=0.2128p ps=1.5u w=1.12u l=0.13u
X38 Q_N a_1430_n843# GND GND sg13_lv_nmos ad=0.1406p pd=1.12u as=0.2516p ps=2.16u w=0.74u l=0.13u
X39 a_2880_n919# DN GND GND sg13_lv_nmos ad=0.1404p pd=1.11u as=0.1368p ps=1.1u w=0.72u l=0.13u
X40 GND a_1659_347# a_1337_207# GND sg13_lv_nmos ad=79.8f pd=0.8u as=0.1428p ps=1.52u w=0.42u l=0.13u
X41 a_171_n602# a_145_n697# VDD VDD sg13_lv_pmos ad=0.34p pd=2.68u as=0.36237p ps=2.605u w=1u l=0.13u
X42 a_1850_130# RST_N GND GND sg13_lv_nmos ad=37.8f pd=0.6u as=79.8f ps=0.8u w=0.42u l=0.13u
X43 a_146_353# a_581_387# a_n114_130# GND sg13_lv_nmos ad=81f pd=0.81u as=0.1296p ps=1.52u w=0.42u l=0.13u
X44 a_528_n529# a_171_n602# VDD VDD sg13_lv_pmos ad=54.6f pd=0.68u as=0.1563p ps=1.22u w=0.42u l=0.13u
X45 a_461_143# a_683_474# a_146_353# GND sg13_lv_nmos ad=0.2163p pd=1.87u as=81f ps=0.81u w=0.42u l=0.13u
X46 Q_N a_1431_207# VDD VDD sg13_lv_pmos ad=0.2128p pd=1.5u as=0.2014p ps=1.53u w=1.12u l=0.13u
X47 VDD Q UP VDD sg13_lv_pmos ad=0.3864p pd=2.93u as=0.2128p ps=1.5u w=1.12u l=0.13u
X48 a_1431_207# a_581_387# a_172_448# VDD sg13_lv_pmos ad=0.19115p pd=1.565u as=0.34p ps=2.68u w=1u l=0.13u
X49 a_1696_445# a_1659_347# a_1620_445# VDD sg13_lv_pmos ad=0.25605p pd=1.935u as=52.5f ps=0.67u w=0.42u l=0.13u
X50 a_1658_n703# a_1430_n843# a_1849_n920# GND sg13_lv_nmos ad=0.1428p pd=1.52u as=37.8f ps=0.6u w=0.42u l=0.13u
X51 GND RST_N a_n20_130# GND sg13_lv_nmos ad=0.1626p pd=1.415u as=60.89999f ps=0.71u w=0.42u l=0.13u
X52 VDD a_1431_207# Q_N VDD sg13_lv_pmos ad=0.2083p pd=1.5u as=0.2128p ps=1.5u w=1.12u l=0.13u
X53 GND RST_N a_n21_n920# GND sg13_lv_nmos ad=0.1626p pd=1.415u as=60.89999f ps=0.71u w=0.42u l=0.13u
X54 a_2880_n919# Q RST_N GND sg13_lv_nmos ad=0.2448p pd=2.12u as=0.1368p ps=1.1u w=0.72u l=0.13u
X55 a_2232_408# a_1431_207# VDD VDD sg13_lv_pmos ad=0.34p pd=2.68u as=0.2083p ps=1.5u w=1u l=0.13u
X56 VDD a_2232_408# Q VDD sg13_lv_pmos ad=0.3808p pd=2.92u as=0.2156p ps=1.505u w=1.12u l=0.13u
X57 GND a_2232_408# Q GND sg13_lv_nmos ad=0.2516p pd=2.16u as=0.1406p ps=1.12u w=0.74u l=0.13u
X58 a_145_n697# a_580_n663# a_528_n529# VDD sg13_lv_pmos ad=79.8f pd=0.8u as=54.6f ps=0.68u w=0.42u l=0.13u
X59 a_n21_n920# VDD a_n115_n920# GND sg13_lv_nmos ad=60.89999f pd=0.71u as=0.1428p ps=1.52u w=0.42u l=0.13u
X60 a_2231_n642# a_1430_n843# VDD VDD sg13_lv_pmos ad=0.34p pd=2.68u as=0.2083p ps=1.5u w=1u l=0.13u
X61 VDD DN RST_N VDD sg13_lv_pmos ad=0.2184p pd=1.51u as=0.2128p ps=1.5u w=1.12u l=0.13u
X62 RST_N Q VDD VDD sg13_lv_pmos ad=0.2128p pd=1.5u as=0.2184p ps=1.51u w=1.12u l=0.13u
X63 GND a_1658_n703# a_1336_n843# GND sg13_lv_nmos ad=79.8f pd=0.8u as=0.1428p ps=1.52u w=0.42u l=0.13u
X64 DN a_2231_n642# GND GND sg13_lv_nmos ad=0.1406p pd=1.12u as=0.2516p ps=2.16u w=0.74u l=0.13u
X65 a_146_353# a_581_387# a_529_521# VDD sg13_lv_pmos ad=79.8f pd=0.8u as=54.6f ps=0.68u w=0.42u l=0.13u
X66 a_1048_n624# a_580_n663# a_682_n576# VDD sg13_lv_pmos ad=0.43102p pd=2.145u as=0.3864p ps=2.93u w=1.12u l=0.13u
X67 a_171_n602# a_682_n576# a_1430_n843# GND sg13_lv_nmos ad=0.3473p pd=2.71u as=0.12665p ps=1.145u w=0.74u l=0.13u
X68 a_n114_130# a_683_474# a_146_353# VDD sg13_lv_pmos ad=0.1428p pd=1.52u as=79.8f ps=0.8u w=0.42u l=0.13u
X69 a_581_387# F_REF a_1049_426# VDD sg13_lv_pmos ad=0.3808p pd=2.92u as=0.43102p ps=2.145u w=1.12u l=0.13u
X70 UP Q VDD VDD sg13_lv_pmos ad=0.2128p pd=1.5u as=0.3808p ps=2.92u w=1.12u l=0.13u
X71 VDD RST_N a_145_n697# VDD sg13_lv_pmos ad=0.1563p pd=1.22u as=0.147p ps=1.54u w=0.42u l=0.13u
X72 GND Q UP GND sg13_lv_nmos ad=0.2516p pd=2.16u as=0.1406p ps=1.12u w=0.74u l=0.13u
X73 GND DN a_2880_n919# GND sg13_lv_nmos ad=0.1368p pd=1.1u as=0.27p ps=2.19u w=0.72u l=0.13u
X74 a_n114_130# VDD VDD VDD sg13_lv_pmos ad=79.8f pd=0.8u as=0.1428p ps=1.52u w=0.42u l=0.13u
X75 a_172_448# a_146_353# VDD VDD sg13_lv_pmos ad=0.34p pd=2.68u as=0.36237p ps=2.605u w=1u l=0.13u
X76 a_460_n907# a_682_n576# a_145_n697# GND sg13_lv_nmos ad=0.2163p pd=1.87u as=81f ps=0.81u w=0.42u l=0.13u
X77 a_397_n907# RST_N GND GND sg13_lv_nmos ad=38.85f pd=0.605u as=0.1701p ps=1.65u w=0.42u l=0.13u
X78 a_1849_n920# RST_N GND GND sg13_lv_nmos ad=37.8f pd=0.6u as=79.8f ps=0.8u w=0.42u l=0.13u
X79 a_n115_n920# a_682_n576# a_145_n697# VDD sg13_lv_pmos ad=0.1428p pd=1.52u as=79.8f ps=0.8u w=0.42u l=0.13u
X80 a_171_n602# a_145_n697# GND GND sg13_lv_nmos ad=0.2516p pd=2.16u as=0.1626p ps=1.415u w=0.74u l=0.13u
X81 VDD Q RST_N VDD sg13_lv_pmos ad=0.392p pd=2.94u as=0.2128p ps=1.5u w=1.12u l=0.13u
X82 GND a_1430_n843# Q_N GND sg13_lv_nmos ad=0.1331p pd=1.12u as=0.1406p ps=1.12u w=0.74u l=0.13u
X83 GND a_2231_n642# DN GND sg13_lv_nmos ad=0.2516p pd=2.16u as=0.1406p ps=1.12u w=0.74u l=0.13u
X84 VDD RST_N a_146_353# VDD sg13_lv_pmos ad=0.1563p pd=1.22u as=0.147p ps=1.54u w=0.42u l=0.13u
X85 VDD a_2231_n642# DN VDD sg13_lv_pmos ad=0.3808p pd=2.92u as=0.2156p ps=1.505u w=1.12u l=0.13u
X86 a_580_n663# F_VCO a_1048_n624# VDD sg13_lv_pmos ad=0.3808p pd=2.92u as=0.43102p ps=2.145u w=1.12u l=0.13u
X87 DN a_2231_n642# VDD VDD sg13_lv_pmos ad=0.2156p pd=1.505u as=0.3808p ps=2.92u w=1.12u l=0.13u
C0 a_683_474# a_581_387# 0.53058f
C1 F_VCO a_580_n663# 0.34338f
C2 a_171_n602# a_460_n907# 0.41224f
C3 a_172_448# a_n114_130# 0.51616f
C4 a_682_n576# a_1430_n843# 0.30906f
C5 VDD a_581_387# 0.23975f
C6 a_682_n576# a_n115_n920# 0.08858f
C7 a_1049_426# RST_N 0.01686f
C8 VDD F_VCO 0.07208f
C9 RST_N a_2880_n919# 0.20166f
C10 a_171_n602# a_580_n663# 0.4437f
C11 Q_N a_1430_n843# 0.07286f
C12 Q_N a_2231_n642# 0.05278f
C13 a_n115_n920# a_460_n907# 0.29725f
C14 a_172_448# RST_N 0.46255f
C15 a_682_n576# RST_N 0.42246f
C16 a_172_448# a_146_353# 0.34866f
C17 a_1048_n624# RST_N 0.02108f
C18 a_1337_207# a_581_387# 0.01037f
C19 a_683_474# a_n114_130# 0.08858f
C20 VDD a_171_n602# 0.07511f
C21 a_1431_207# a_172_448# 0.01501f
C22 a_n115_n920# a_580_n663# 0.02488f
C23 DN a_2231_n642# 0.15777f
C24 a_1431_207# a_2232_408# 0.0513f
C25 a_171_n602# F_VCO 0.11157f
C26 a_145_n697# a_580_n663# 0.02202f
C27 a_1431_207# Q_N 0.07288f
C28 DN RST_N 0.20935f
C29 a_172_448# a_461_143# 0.41224f
C30 VDD a_n114_130# 0.89476f
C31 RST_N a_580_n663# 0.04754f
C32 a_683_474# RST_N 0.41744f
C33 VDD a_1430_n843# 0.28952f
C34 a_n114_130# a_581_387# 0.02488f
C35 VDD a_n115_n920# 0.86676f
C36 a_1659_347# Q_N 0.16081f
C37 a_172_448# F_REF 0.11119f
C38 VDD a_2231_n642# 0.5527f
C39 VDD a_145_n697# 0.09235f
C40 a_1431_207# a_683_474# 0.30906f
C41 VDD RST_N 3.42726f
C42 VDD a_146_353# 0.09235f
C43 a_581_387# RST_N 0.05692f
C44 a_581_387# a_146_353# 0.02202f
C45 Q a_2880_n919# 0.02668f
C46 a_1659_347# a_683_474# 0.04589f
C47 F_VCO RST_N 0.02024f
C48 a_968_n899# a_580_n663# 0.03849f
C49 a_461_143# a_683_474# 0.08237f
C50 VDD a_1431_207# 0.29867f
C51 a_171_n602# a_1430_n843# 0.01501f
C52 a_171_n602# a_n115_n920# 0.51616f
C53 a_683_474# F_REF 0.01104f
C54 Q a_2232_408# 0.16181f
C55 a_1336_n843# a_580_n663# 0.01037f
C56 a_145_n697# a_171_n602# 0.34866f
C57 a_1659_347# VDD 0.14379f
C58 VDD UP 0.36879f
C59 a_171_n602# RST_N 0.40948f
C60 a_461_143# a_581_387# 0.02489f
C61 VDD F_REF 0.07363f
C62 RST_N a_1695_n605# 0.01791f
C63 a_581_387# F_REF 0.3429f
C64 a_2231_n642# a_1430_n843# 0.0513f
C65 a_1431_207# a_1337_207# 0.29283f
C66 Q DN 0.03849f
C67 a_145_n697# a_n115_n920# 0.78507f
C68 a_682_n576# a_1658_n703# 0.04589f
C69 a_n114_130# RST_N 0.09175f
C70 a_n114_130# a_146_353# 0.78507f
C71 RST_N a_1430_n843# 0.14048f
C72 a_n115_n920# RST_N 0.1282f
C73 a_969_151# a_172_448# 0.02051f
C74 Q_N a_1658_n703# 0.16081f
C75 RST_N a_2231_n642# 0.01012f
C76 a_968_n899# a_171_n602# 0.02051f
C77 a_145_n697# RST_N 0.26588f
C78 VDD Q 0.88942f
C79 a_146_353# RST_N 0.22959f
C80 a_1336_n843# a_171_n602# 0.42376f
C81 a_461_143# a_n114_130# 0.29725f
C82 a_1431_207# RST_N 0.14259f
C83 a_682_n576# a_1048_n624# 0.02037f
C84 a_1336_n843# a_1430_n843# 0.29283f
C85 a_1659_347# RST_N 0.12342f
C86 VDD a_1658_n703# 0.14177f
C87 Q_N a_2232_408# 0.05278f
C88 a_682_n576# a_460_n907# 0.08237f
C89 a_461_143# RST_N 0.01333f
C90 a_683_474# a_1049_426# 0.02037f
C91 DN a_2880_n919# 0.09464f
C92 RST_N F_REF 0.02268f
C93 a_1659_347# a_1431_207# 0.39948f
C94 a_969_151# a_581_387# 0.03849f
C95 a_682_n576# a_580_n663# 0.53058f
C96 a_172_448# a_683_474# 0.3005f
C97 a_1048_n624# a_580_n663# 0.01711f
C98 a_1049_426# a_581_387# 0.01711f
C99 a_1696_445# RST_N 0.01561f
C100 VDD a_2880_n919# 0.0292f
C101 a_460_n907# a_580_n663# 0.02489f
C102 a_1695_n605# a_1658_n703# 0.01442f
C103 VDD a_172_448# 0.07621f
C104 VDD a_682_n576# 0.1814f
C105 Q RST_N 0.85522f
C106 a_172_448# a_581_387# 0.4437f
C107 VDD a_2232_408# 0.55758f
C108 a_682_n576# F_VCO 0.01106f
C109 VDD Q_N 0.6471f
C110 a_1659_347# a_1696_445# 0.01442f
C111 a_1430_n843# a_1658_n703# 0.39948f
C112 Q UP 0.29508f
C113 a_1337_207# a_172_448# 0.42376f
C114 VDD DN 0.60005f
C115 VDD a_580_n663# 0.22704f
C116 RST_N a_1658_n703# 0.122f
C117 VDD a_683_474# 0.18353f
C118 a_682_n576# a_171_n602# 0.3005f
R0 Y.n1 Y.n0 33.4092
R1 Y.n4 Y.n3 33.4092
R2 Y.n2 Y.n1 15.0283
R3 Y.n5 Y.n4 15.0223
R4 RST_N Y 14.8425
R5 Y.n6 Y.n5 9.46714
R6 RST_N Y.n2 9.02795
R7 Y.n6 RST_N 0.369454
R8 Y.n5 RESET_B 0.0754451
R9 Y.n2 RESET_B 0.0694011
R10 RST_N Y.n6 0.0471939
R11 VDD.n16 VDD.n1 17.5138
R12 VDD.n5 VDD.n4 17.5138
R13 VDD.n10 VDD.n9 17.0005
R14 VDD.n15 VDD.n0 17.0005
R15 VDD.n13 VDD.n12 15.0144
R16 VDD.n3 VDD.n2 15.0036
R17 VDD.n9 VDD.n8 4.39065
R18 VDD.n18 VDD 3.52544
R19 VDD.n7 VDD 3.52544
R20 VDD.n19 VDD.n0 3.05276
R21 VDD.n17 VDD.n16 1.25491
R22 VDD.n6 VDD.n5 1.23733
R23 VDD.n7 VDD.n6 1.18491
R24 VDD.n18 VDD.n17 1.16733
R25 VDD.n14 VDD.n11 0.6792
R26 VDD.n11 VDD 0.627547
R27 VDD.n14 VDD 0.4625
R28 VDD VDD.n13 0.341218
R29 VDD.n9 VDD.n6 0.256392
R30 VDD.n17 VDD.n0 0.256392
R31 VDD.n8 VDD 0.255237
R32 VDD.n19 VDD 0.255237
R33 VDD.n11 VDD.n3 0.2513
R34 VDD VDD.n14 0.184824
R35 VDD.n19 VDD.n18 0.160896
R36 VDD.n8 VDD.n7 0.160896
R37 VDD.n3 D 0.0733169
R38 VDD.n13 D 0.0624718
R39 VDD VDD.n10 0.0605
R40 VDD.n15 VDD 0.0605
R41 VDD.n10 VDD.n5 0.0255
R42 VDD.n16 VDD.n15 0.0255
R43 VDD.n8 VDD 0.02425
R44 VDD VDD.n19 0.02425
R45 A.n3 A.n2 15.0255
R46 A.n1 A.n0 15.0042
R47 A.n4 A.n1 10.9022
R48 Q A.n4 9.42191
R49 A.n4 A.n3 9.0005
R50 A.n3 A 0.0471667
R51 A.n1 A 0.0377881
R52 VSS.n3 VSS.n1 7007.13
R53 VSS.n5 VSS.n1 4.17719
R54 VSS.n4 VSS.n3 2.72142
R55 VSS.n5 VSS.n4 2.39159
R56 VSS.n2 VSS 1.34928
R57 VSS VSS.n0 1.34079
R58 VSS.n0 GND 1.23785
R59 VSS.n2 GND 1.22406
R60 VSS.n4 VSS 0.356592
R61 VSS VSS.n5 0.24028
R62 VSS.n1 VSS.n0 0.235919
R63 VSS.n3 VSS.n2 0.231732
R64 B.n1 B.n0 15.0201
R65 DN Q 9.43209
R66 DN B.n1 9.41058
R67 B.n1 B 0.0928214
R68 CLK.n1 CLK.n0 15.0353
R69 F_VCO CLK.n1 9.06422
R70 CLK.n1 CLK 0.0555
R71 GND.n4 GND.n3 7007.13
R72 GND.n3 GND.n2 4.17719
R73 GND.n4 GND.n0 2.72093
R74 GND.n2 GND.n0 2.39226
R75 VSS GND.n5 1.34364
R76 VSS GND.n1 1.34079
R77 GND.n1 GND 1.23785
R78 GND.n5 GND 1.23785
R79 VSS GND.n0 0.355888
R80 GND.n2 VSS 0.24028
R81 GND.n3 GND.n1 0.235919
R82 GND.n5 GND.n4 0.235919
R83 D.n10 D.n9 17.5138
R84 D.n1 D.n0 17.5138
R85 D.n15 D.n14 17.0005
R86 D.n6 D.n5 17.0005
R87 D.n19 D.n18 15.0144
R88 D.n8 D.n7 15.0036
R89 D.n14 D.n13 4.39065
R90 D.n12 VDD 3.52544
R91 D.n3 VDD 3.52544
R92 D.n5 D.n2 3.05346
R93 D.n4 D.n1 1.25491
R94 D.n11 D.n10 1.23733
R95 D.n12 D.n11 1.18491
R96 D.n4 D.n3 1.16733
R97 D.n17 D.n16 0.6792
R98 D.n16 VDD 0.627547
R99 VDD D.n17 0.4625
R100 VDD D.n19 0.341218
R101 D.n14 D.n11 0.256392
R102 D.n5 D.n4 0.256392
R103 D.n13 VDD 0.255237
R104 D.n2 VDD 0.255237
R105 D.n16 D.n8 0.2513
R106 D.n17 VDD 0.184824
R107 D.n13 D.n12 0.160896
R108 D.n3 D.n2 0.160896
R109 D.n8 D 0.0733169
R110 D.n19 D 0.0624718
R111 VDD D.n15 0.0605
R112 VDD D.n6 0.0605
R113 D.n15 D.n10 0.0255
R114 D.n6 D.n1 0.0255
R115 D.n13 VDD 0.02425
R116 D.n2 VDD 0.02425
R117 Q.n1 Q.n0 15.0201
R118 DN Q 9.43209
R119 DN Q.n1 9.41058
R120 Q.n1 B 0.0928214
R121 RESET_B.n4 RESET_B.n3 33.4092
R122 RESET_B.n1 RESET_B.n0 33.4092
R123 RESET_B.n2 RESET_B.n1 15.0283
R124 RESET_B.n5 RESET_B.n4 15.0223
R125 RST_N Y 14.8425
R126 RESET_B.n6 RESET_B.n5 9.46714
R127 RST_N RESET_B.n2 9.02795
R128 RST_N RESET_B.n6 0.369454
R129 RESET_B.n5 RESET_B 0.0754451
R130 RESET_B.n2 RESET_B 0.0694011
R131 RESET_B.n6 RST_N 0.0471939
R132 RST_N.n1 RST_N.n0 33.4092
R133 RST_N.n4 RST_N.n3 33.4092
R134 RST_N.n2 RST_N.n1 15.0283
R135 RST_N.n5 RST_N.n4 15.0223
R136 Y RST_N 14.8425
R137 RST_N.n6 RST_N.n5 9.46714
R138 RST_N RST_N.n2 9.02795
R139 RST_N.n6 RST_N 0.369454
R140 RST_N.n5 RESET_B 0.0754451
R141 RST_N.n2 RESET_B 0.0694011
R142 RST_N RST_N.n6 0.0471939
R143 Y UP 9.24457
R144 F_VCO.n1 F_VCO.n0 15.0353
R145 F_VCO.n1 F_VCO 9.06422
R146 CLK F_VCO.n1 0.0555
R147 F_REF.n1 F_REF.n0 15.0445
R148 F_REF.n1 F_REF 9.07181
R149 CLK F_REF.n1 0.0463333
R150 DN.n1 DN.n0 15.0201
R151 Q DN 9.43209
R152 DN DN.n1 9.41058
R153 DN.n1 B 0.0928214
C119 Q_N GND 0.29123f
C120 DN GND 0.84962f
C121 Q GND 1.76091f
C122 F_VCO GND 0.26308f
C123 UP GND 0.3086f
C124 F_REF GND 0.25992f
C125 RST_N GND 2.53818f
C126 VDD GND 2.47307f
C127 a_2880_n919# GND 0.44057f $ **FLOATING
C128 a_1336_n843# GND 0.09171f $ **FLOATING
C129 a_460_n907# GND 0.03574f $ **FLOATING
C130 a_2231_n642# GND 0.72676f $ **FLOATING
C131 a_1658_n703# GND 0.30028f $ **FLOATING
C132 a_1430_n843# GND 0.95142f $ **FLOATING
C133 a_682_n576# GND 0.3603f $ **FLOATING
C134 a_580_n663# GND 0.79475f $ **FLOATING
C135 a_171_n602# GND 1.57954f $ **FLOATING
C136 a_n115_n920# GND 0.18121f $ **FLOATING
C137 a_145_n697# GND 0.24079f $ **FLOATING
C138 a_1337_207# GND 0.09171f $ **FLOATING
C139 a_461_143# GND 0.03574f $ **FLOATING
C140 a_2232_408# GND 0.72199f $ **FLOATING
C141 a_1659_347# GND 0.29838f $ **FLOATING
C142 a_1431_207# GND 0.94268f $ **FLOATING
C143 a_683_474# GND 0.35899f $ **FLOATING
C144 a_581_387# GND 0.7728f $ **FLOATING
C145 a_172_448# GND 1.57629f $ **FLOATING
C146 a_n114_130# GND 0.16295f $ **FLOATING
C147 a_146_353# GND 0.24261f $ **FLOATING
.ends
