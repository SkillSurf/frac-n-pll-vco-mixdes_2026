.SUBCKT LC_VCO VDD OUTP OUTN IBIAS VCTRL GND
*.PININFO VDD:B OUTP:O OUTN:O GND:B VCTRL:B IBIAS:B

M6 net1 IBIAS GND GND sg13_lv_nmos w=1u l=0.15u m=60
M5 IBIAS IBIAS GND GND sg13_lv_nmos w=1u l=0.15u m=1

M4 OUTP OUTN VDD VDD sg13_lv_pmos w=8.5u l=0.5u m=13
M3 OUTN OUTP VDD VDD sg13_lv_pmos w=8.5u l=0.5u m=13

M2 OUTP OUTN net1 GND sg13_lv_nmos w=2u l=0.5u m=12
M1 OUTN OUTP net1 GND sg13_lv_nmos w=2u l=0.5u m=12

XC3 OUTP OUTN cap_cmim w=4e-6 l=4e-6 m=14

Mv2 OUTP VCTRL OUTP VDD sg13_lv_pmos w=4u l=4u m=22
Mv1 OUTN VCTRL OUTN VDD sg13_lv_pmos w=4u l=4u m=22

XR1 OUTN OUTP GND rhigh w=1e-6 l=1e-6 m=1

x1 OUTN OUTP IHP_4nH_Inductor

.ENDS

.SUBCKT IHP_4nH_Inductor p n
L1 p n 4n
.ENDS

.GLOBAL VDD
.GLOBAL GND
