* Extracted by KLayout with SG13G2 LVS runset on : 18/03/2026 14:44

.SUBCKT CP_lvs 1 4 5 6 7 8 12 13 14
C$1 14 1 cap_cmim w=15u l=20u A=300p P=70u m=4
C$5 12 1 cap_cmim w=40u l=40u A=1600p P=160u m=4
C$9 13 1 cap_cmim w=60u l=60u A=3600p P=240u m=1
M$10 1 6 2 1 sg13_lv_nmos L=2u W=3u AS=1.02p AD=1.02p PS=6.68u PD=6.68u
M$11 3 5 14 1 sg13_lv_nmos L=2u W=3u AS=1.02p AD=1.02p PS=6.68u PD=6.68u
M$12 1 4 3 1 sg13_lv_nmos L=2u W=3u AS=1.02p AD=1.02p PS=6.68u PD=6.68u
M$13 2 5 5 1 sg13_lv_nmos L=2u W=3u AS=1.02p AD=1.02p PS=6.68u PD=6.68u
M$14 6 1 10 6 sg13_lv_pmos L=2u W=10u AS=3.4p AD=3.4p PS=20.68u PD=20.68u
M$15 6 1 9 6 sg13_lv_pmos L=2u W=10u AS=3.4p AD=3.4p PS=20.68u PD=20.68u
M$16 11 7 14 6 sg13_lv_pmos L=2u W=10u AS=3.4p AD=3.4p PS=20.68u PD=20.68u
M$17 6 8 11 6 sg13_lv_pmos L=2u W=10u AS=3.4p AD=3.4p PS=20.68u PD=20.68u
M$18 9 7 7 6 sg13_lv_pmos L=2u W=10u AS=3.4p AD=3.4p PS=20.68u PD=20.68u
M$19 10 7 5 6 sg13_lv_pmos L=2u W=10u AS=3.4p AD=3.4p PS=20.68u PD=20.68u
R$26 12 14 rsil w=0.5u l=2500u ps=0 b=0 m=1
R$49 13 14 rsil w=0.5u l=1000u ps=0 b=0 m=1
.ENDS CP_lvs
