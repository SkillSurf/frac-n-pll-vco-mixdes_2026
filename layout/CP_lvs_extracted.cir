* Extracted by KLayout with SG13G2 LVS runset on : 21/03/2026 09:37

.SUBCKT CP_lvs
M$1 4 5 5 1 sg13_lv_nmos L=2u W=3u AS=1.02p AD=1.02p PS=6.68u PD=6.68u
M$2 6 5 27 1 sg13_lv_nmos L=2u W=3u AS=1.02p AD=1.02p PS=6.68u PD=6.68u
M$3 1 8 4 1 sg13_lv_nmos L=2u W=3u AS=1.02p AD=1.02p PS=6.68u PD=6.68u
M$4 1 7 6 1 sg13_lv_nmos L=2u W=3u AS=1.02p AD=1.02p PS=6.68u PD=6.68u
M$5 8 10 13 8 sg13_lv_pmos L=2u W=10u AS=3.4p AD=3.4p PS=20.68u PD=20.68u
M$6 13 9 27 8 sg13_lv_pmos L=2u W=10u AS=3.4p AD=3.4p PS=20.68u PD=20.68u
M$7 8 1 12 8 sg13_lv_pmos L=2u W=10u AS=3.4p AD=3.4p PS=20.68u PD=20.68u
M$8 12 9 5 8 sg13_lv_pmos L=2u W=10u AS=3.4p AD=3.4p PS=20.68u PD=20.68u
M$9 8 1 11 8 sg13_lv_pmos L=2u W=10u AS=3.4p AD=3.4p PS=20.68u PD=20.68u
M$10 11 9 9 8 sg13_lv_pmos L=2u W=10u AS=3.4p AD=3.4p PS=20.68u PD=20.68u
R$11 16 2 rsil w=0.5u l=100u ps=0 b=0 m=1
R$12 16 18 rsil w=0.5u l=100u ps=0 b=0 m=1
R$13 17 18 rsil w=0.5u l=100u ps=0 b=0 m=1
R$14 17 20 rsil w=0.5u l=100u ps=0 b=0 m=1
R$15 19 20 rsil w=0.5u l=100u ps=0 b=0 m=1
R$16 19 22 rsil w=0.5u l=100u ps=0 b=0 m=1
R$17 21 22 rsil w=0.5u l=100u ps=0 b=0 m=1
R$18 21 24 rsil w=0.5u l=100u ps=0 b=0 m=1
R$19 23 24 rsil w=0.5u l=100u ps=0 b=0 m=1
R$20 23 27 rsil w=0.5u l=100u ps=0 b=0 m=1
R$21 25 27 rsil w=0.5u l=100u ps=0 b=0 m=1
R$22 25 26 rsil w=0.5u l=100u ps=0 b=0 m=1
R$23 29 26 rsil w=0.5u l=100u ps=0 b=0 m=1
R$24 29 30 rsil w=0.5u l=100u ps=0 b=0 m=1
R$25 28 30 rsil w=0.5u l=100u ps=0 b=0 m=1
R$26 28 31 rsil w=0.5u l=100u ps=0 b=0 m=1
R$27 32 31 rsil w=0.5u l=100u ps=0 b=0 m=1
R$28 32 33 rsil w=0.5u l=100u ps=0 b=0 m=1
R$29 34 33 rsil w=0.5u l=100u ps=0 b=0 m=1
R$30 34 36 rsil w=0.5u l=100u ps=0 b=0 m=1
R$31 35 36 rsil w=0.5u l=100u ps=0 b=0 m=1
R$32 35 37 rsil w=0.5u l=100u ps=0 b=0 m=1
R$33 38 37 rsil w=0.5u l=100u ps=0 b=0 m=1
R$34 38 40 rsil w=0.5u l=100u ps=0 b=0 m=1
R$35 39 40 rsil w=0.5u l=100u ps=0 b=0 m=1
R$36 39 42 rsil w=0.5u l=100u ps=0 b=0 m=1
R$37 41 42 rsil w=0.5u l=100u ps=0 b=0 m=1
R$38 41 43 rsil w=0.5u l=100u ps=0 b=0 m=1
R$39 44 43 rsil w=0.5u l=100u ps=0 b=0 m=1
R$40 44 45 rsil w=0.5u l=100u ps=0 b=0 m=1
R$41 46 45 rsil w=0.5u l=100u ps=0 b=0 m=1
R$42 46 48 rsil w=0.5u l=100u ps=0 b=0 m=1
R$43 47 48 rsil w=0.5u l=100u ps=0 b=0 m=1
R$44 47 49 rsil w=0.5u l=100u ps=0 b=0 m=1
R$45 3 49 rsil w=0.5u l=100u ps=0 b=0 m=1
C$46 3 1 cap_cmim w=40u l=40u A=1600p P=160u m=1
C$47 2 1 cap_cmim w=60u l=60u A=3600p P=240u m=1
C$48 3 1 cap_cmim w=40u l=40u A=1600p P=160u m=1
C$49 27 1 cap_cmim w=20u l=15u A=300p P=70u m=1
C$50 27 1 cap_cmim w=20u l=15u A=300p P=70u m=1
C$51 3 1 cap_cmim w=40u l=40u A=1600p P=160u m=1
C$52 27 1 cap_cmim w=20u l=15u A=300p P=70u m=1
C$53 3 1 cap_cmim w=40u l=40u A=1600p P=160u m=1
C$54 27 1 cap_cmim w=20u l=15u A=300p P=70u m=1
.ENDS CP_lvs
