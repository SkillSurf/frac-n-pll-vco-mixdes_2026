* Extracted by KLayout with SG13G2 LVS runset on : 18/03/2026 21:30

.SUBCKT sg13g2_inv_2$1 1 2 3 4
M$1 1 3 2 1 sg13_lv_nmos L=0.13u W=1.48u AS=0.3922p AD=0.3922p PS=3.28u PD=3.28u
M$3 4 3 2 4 sg13_lv_pmos L=0.13u W=2.24u AS=0.5936p AD=0.5992p PS=4.42u PD=4.43u
.ENDS sg13g2_inv_2$1
